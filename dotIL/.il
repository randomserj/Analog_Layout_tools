/*******************************************************************

                                    *   *
                                        *
                                    *   *
                                *   *   *

	Bindkeys:

	- <Key>F4 to build an array from syncClones
	- <Key>; to load/save via templates and to add/remove stacks
	- <KeyF5> to change grid
	- <Key>1..9 to toggle metals+vias visiability
	- ctrl<Key>1..9 to add/remove metal+via to/from visiability list
	- <Key>0 to show/hide FEOL layers
	- ctrl<Key>0 to add/remove FEOL layers to/from visiability list
	- <Key>` to show all layers
	- <Key>\ to mark a net in the hierarchy
	- shift<Key>\ to remove all marked nets

*******************************************************************/

dilPrefix = "[.il]"
dilFormGrid = 10
dilTechFile = nil
dilGrid = nil
dilDiff = list()
dilImps = list()
dilPolys = list()
dilWells = list()
dilMetals = list()
dilPins = list()
dilVias = list()
dilMetalWidthList = list()	;;; <----- list with metal name, minWidth=width of Mx to Mx+1 VIA and VIA + step to increse width, e.g. list( list(0.13 0.07+0.09) )
dilSmartViaFile = strcat( getWorkingDir() "/.il/vias.tmpl" )
dilAlphabet = list("A" "B" "C" "D" "E" "F" "G" "H" "I" "K" "L" "M" "N" "O" "P" "Q" "R" "S" "T")

procedure( DILPrint(message @optional messageType)
let( ()
	printf("%s\t*** %L ***\t\t%s\n" dilPrefix messageType message)
);let
);procedure

procedure( DILLoadSKILL()
let( (path dir dirs file files)
	dirs = list( "scripts" "scripts/misc")
	foreach( dir dirs
		path = strcat( dilHome "/" dir)
		DILPrint( strcat("Loading " dir) "INFO"  )
		files = cddr( sort( getDirFiles(path) nil ) )
		foreach( file files loadi(strcat(path "/" file)) )
	)
);let
);procedure

procedure( DILEditConfig()
let( ()
	DILPrint("The code is not yet ready :)" "WIP")
);let
);procedure

procedure( DILLoadConfig()
let( (file line (info "") (toRead nil) block layer layers)
	;file = infile( strcat(getWorkingDir() "/.il/config") )
	file = infile(strcat(getShellEnvVar("HOME") "/cdns/config")) ;; for developing
	when( file
		while( gets(line file)
			if( line != "\n" then line = car(parseString(line "\n")) else toRead = nil )
			when( toRead
				case( block
					("tech" when( ddGetObj(line) dilTechFile = techGetTechFile(ddGetObj(line))))
					("grid" dilGrid = atof(line))
					("metals" dilMetals = parseString(line))
					("pins" dilPins = parseString(line))
				)
			)
			when( rexMatchp("^[[].*[]]$" line)
				toRead = t
				block = car(parseString(line "[]"))
			)
		)
		if( dilTechFile then
			DILPrint( strcat("Getting informaition from " dilTechFile~>libName " tech file") "INFO")
			layers = techGetLayerFunctions(dilTechFile)
			foreach( layer layers
				if( cadr(layer) == "poly" then dilPolys = append1(dilPolys car(layer)) )
				if( cadr(layer) == "cut" then dilVias = append1(dilVias car(layer)) )
				if( cadr(layer) == "diff" then dilDiff = append1(dilDiff car(layer)) )
				if( cadr(layer) == "nplus" || cadr(layer) == "pplus" then dilImps = append1(dilImps car(layer)) )
				if( cadr(layer) == "nwell" then dilWells = append1(dilWells car(layer)) )
			)
			DILLoadSKILL()
		else
			DILPrint( "Tech library is missed" "ERROR" )
		)
	)
);let
);procedure

procedure( DILAbout()
let( (file line (info "") (endOfInfo nil))
	file = infile( strcat(dilHome "/.il") )
	when( file
		while( gets(line file)
			when( line == "\n" endOfInfo = t )
			when( !endOfInfo && !rexMatchp("^/.*$" line)
				DILPrint( sprintf(nil "%s%s" info line) )
			)
		)
	)
);let
);procedure

/*** Adding main menu to CIW ***/
let( (items)
	createDir( strcat(getWorkingDir() "/.il") )
	ciwMenuInit()
	items = list(
			hiCreateMenuItem(
				?name 'itemEditConfig
				?itemText "Edit Config"
				?callback "DILEditConfig()"
			)
			hiCreateMenuItem(
				?name 'itemLoadConfig
				?itemText "Load Config"
				?callback "DILLoadConfig()"
			)
			hiCreateMenuItem(
				?name 'itemILog
				?itemText "About"
				?callback "DILAbout()"
			)
	)
	menuDIL = hiCreatePulldownMenu(
			'menuDIL
			".il"
			items
	)
	if( hiInsertBannerMenu( window(1) menuDIL hiGetNumMenus(window(1)) )
		DILPrint( "Menu \".il\" has been added to CIW" "INFO" )
	)
);let
