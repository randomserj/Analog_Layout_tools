procedure( lDILGetTextBoundary(g)
let( (f fs bnd)
	fs = g~>figs
	foreach(f fs
		when( f~>objType == "rect" && f~>layerName == "text" bnd = f )
	)
	bnd
);let
);procedure

procedure( lDILGetRectDimensions(r)
let( (bBox w l)
	bBox = r~>bBox
	w = abs(caar(bBox) - caadr(bBox))
	l = abs(cadar(bBox) - cadadr(bBox))
	list(w l)
);let
);procedure

procedure( lDILAttachLabel(g l)
let( (cv bnd bBox xC yC lbl)
	cv = geGetEditCellView()
	bnd = lDILGetTextBoundary(g)
	bBox = bnd~>bBox
	xC = atof(sprintf( nil "%.2f" (caar(bBox) + caadr(bBox))/2 ))
	yC = atof(sprintf( nil "%.2f" (cadar(bBox) + cadadr(bBox))/2 ))
	lbl = dbCreateLabel(
		cv
		list("text" "drawing")
		list(xC yC)
		l
		"centerCenter"
		"R0"
		"roman"
		cadr(lDILGetRectDimensions(fig))/2
	)
	leAttachFig(
		lbl
		g
	)
);let
);procedure

procedure( cbGroupMove(o action m)
let( (orig new s)
	orig = o~>origin
	dprint(orig)
	s = techGetMfgGridResolution(dilTechFile) * m
	case( action
		( "u" new = list(car(orig) cadr(orig)+s) )
		( "d" new = list(car(orig) cadr(orig)-s) )
		( "l" new = list(car(orig)-s cadr(orig)) )
		( "r" new = list(car(orig)+s cadr(orig)) )
	)
	obj~>origin = new
);let
);procedure

procedure( cbPlaceGroup(group pattern)
let( (cv bnd row rows item items fig lbl i j dx dy)
	cv = geGetEditCellView()
	bnd = lDILGetTextBoundary(group)
	dx = car(lDILGetRectDimensions(bnd))
	dy = cadr(lDILGetRectDimensions(bnd))
	rows = parseString(pattern "\n")
	j = 0
	foreach(row rows
		i = 0
		items = parseString(row "")
		foreach(item items
			when(item != " " && i - j != 0
				fig = dbCopyFig(
					group
					cv
					list(
						list(i*dx j*dy)
						"R0"
						1
					)
				)
				lDILAttachLabel(fig item)
			)
			i++
		)
		j--
	)
	lDILAttachLabel(group substring(pattern 1 1))
);let
);procedure
